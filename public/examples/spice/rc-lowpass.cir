* RC low-pass filter, corner near 1.59 kHz. Example for the engineering map (CC0).
V1 in 0 AC 1 SIN(0 1 1k)
R1 in out 1k
C1 out 0 100n
.ac dec 20 10 1meg
.tran 10u 5m
.end
